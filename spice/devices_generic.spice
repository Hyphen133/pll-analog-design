* Generic level-1 stand-ins for the IHP SG13G2 primitives.
*
* These exist so the architecture can be simulated on a plain ngspice build.
* The IHP models are PSP103 Verilog-A and need an OSDI binary that this
* toolchain does not have; see docs/simulation.md.
*
* Absolute frequencies, currents and Kvco from these models are NOT
* representative of silicon.  Use them to verify topology, polarity and
* loop behaviour only; sign off with devices_ihp.spice.

.model nch nmos level=1 vto=0.45 kp=320u gamma=0.4 lambda=0.08 tox=3n
+ cgso=2e-10 cgdo=2e-10 cj=1e-3 cjsw=2e-10
.model pch pmos level=1 vto=-0.45 kp=110u gamma=0.4 lambda=0.08 tox=3n
+ cgso=2e-10 cgdo=2e-10 cj=1e-3 cjsw=2e-10

.subckt sg13_lv_nmos d g s b w=1u l=0.13u ng=1 m=1 as=0 ad=0 ps=0 pd=0
mn d g s b nch w=w l=l m=m
.ends sg13_lv_nmos

.subckt sg13_lv_pmos d g s b w=1u l=0.13u ng=1 m=1 as=0 ad=0 ps=0 pd=0
mp d g s b pch w=w l=l m=m
.ends sg13_lv_pmos

* Sheet-resistance model matching the PDK rhigh: 1360 ohm/square.
.subckt rhigh 1 2 bn w=1u l=1u
r1 1 2 r='1360 * l / w'
.ends rhigh

* MIM capacitor matching the PDK cap_cmim: 1.5 fF/um^2.
.subckt cap_cmim plus minus w=1u l=1u
c1 plus minus c='1.5e-15 * (w/1u) * (l/1u)'
.ends cap_cmim
